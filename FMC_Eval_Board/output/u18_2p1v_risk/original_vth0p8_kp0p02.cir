U18 held-rail stress check: corrected=False, carrierpullups=False
* Holding rail with a voltage source is a boundary condition, NOT LDO behavior.
* Positive I(Vrail) is current which the real rail load/regulator must absorb.
* Generic MOS equivalent, no manufacturer fitted parameters, no damage model.
.options reltol=1e-7 abstol=1e-12 vntol=1e-9
Vrail rail 0 2.1
Vhigh high 0 3.3
R56 high en 10k
Vlink high ref2 0
Mref ref2 en rail 0 PASS W=1u L=1u
Mscl sclh en scll 0 PASS W=1u L=1u
Msda sdah en sdal 0 PASS W=1u L=1u
.model PASS NMOS(LEVEL=1 VTO=0.8 KP=0.02 GAMMA=0 LAMBDA=0)
R53 rail sdal 10k
R54 rail scll 10k
R57 high sclh 10k
R58 high sdah 10k
* FMC disconnected
.dc Vrail 1.7 2.7 .01
.save v(rail) v(en) v(scll) v(sclh) i(Vrail) @mref[id]
.end
