ADS5282 sample-clock 10MHz Rdriver=25 edge=1ns R165=False
* Behavioral sensitivity only; no vendor FPGA IBIS or ADC transistor model.
* FPGA P switches 0..1.8V; FPGA N actively driven low.
* R165 is at the daughtercard connector, before about78mm card routing.
* UIC capacitor precharge represents periodic steady operation, not startup.
Vp sp 0 PULSE(0 1.8 25n 1n 1n 49n 100n)
Vn sn 0 0
Rp sp dp 25
Rn sn dn 25
Ccarrierp_first dp 0 6.96510534205e-13
Rcarrierp_0 dp carrierp_r0 0.133333333333
Lcarrierp_0 carrierp_r0 carrierp_v0 3.48255267103e-09
Ccarrierp_0 carrierp_v0 0 1.39302106841e-12
Rcarrierp_1 carrierp_v0 carrierp_r1 0.133333333333
Lcarrierp_1 carrierp_r1 carrierp_v1 3.48255267103e-09
Ccarrierp_1 carrierp_v1 0 1.39302106841e-12
Rcarrierp_2 carrierp_v1 carrierp_r2 0.133333333333
Lcarrierp_2 carrierp_r2 carrierp_v2 3.48255267103e-09
Ccarrierp_2 carrierp_v2 0 1.39302106841e-12
Rcarrierp_3 carrierp_v2 carrierp_r3 0.133333333333
Lcarrierp_3 carrierp_r3 carrierp_v3 3.48255267103e-09
Ccarrierp_3 carrierp_v3 0 1.39302106841e-12
Rcarrierp_4 carrierp_v3 carrierp_r4 0.133333333333
Lcarrierp_4 carrierp_r4 carrierp_v4 3.48255267103e-09
Ccarrierp_4 carrierp_v4 0 1.39302106841e-12
Rcarrierp_5 carrierp_v4 carrierp_r5 0.133333333333
Lcarrierp_5 carrierp_r5 carrierp_v5 3.48255267103e-09
Ccarrierp_5 carrierp_v5 0 1.39302106841e-12
Rcarrierp_6 carrierp_v5 carrierp_r6 0.133333333333
Lcarrierp_6 carrierp_r6 carrierp_v6 3.48255267103e-09
Ccarrierp_6 carrierp_v6 0 1.39302106841e-12
Rcarrierp_7 carrierp_v6 carrierp_r7 0.133333333333
Lcarrierp_7 carrierp_r7 carrierp_v7 3.48255267103e-09
Ccarrierp_7 carrierp_v7 0 1.39302106841e-12
Rcarrierp_8 carrierp_v7 carrierp_r8 0.133333333333
Lcarrierp_8 carrierp_r8 carrierp_v8 3.48255267103e-09
Ccarrierp_8 carrierp_v8 0 1.39302106841e-12
Rcarrierp_9 carrierp_v8 carrierp_r9 0.133333333333
Lcarrierp_9 carrierp_r9 carrierp_v9 3.48255267103e-09
Ccarrierp_9 carrierp_v9 0 1.39302106841e-12
Rcarrierp_10 carrierp_v9 carrierp_r10 0.133333333333
Lcarrierp_10 carrierp_r10 carrierp_v10 3.48255267103e-09
Ccarrierp_10 carrierp_v10 0 1.39302106841e-12
Rcarrierp_11 carrierp_v10 carrierp_r11 0.133333333333
Lcarrierp_11 carrierp_r11 jp 3.48255267103e-09
Ccarrierp_11 jp 0 6.96510534205e-13
Ccardp_first jp 0 4.01988386507e-13
Rcardp_0 jp cardp_r0 0.0166666666667
Lcardp_0 cardp_r0 cardp_v0 2.00994193253e-09
Ccardp_0 cardp_v0 0 8.03976773013e-13
Rcardp_1 cardp_v0 cardp_r1 0.0166666666667
Lcardp_1 cardp_r1 cardp_v1 2.00994193253e-09
Ccardp_1 cardp_v1 0 8.03976773013e-13
Rcardp_2 cardp_v1 cardp_r2 0.0166666666667
Lcardp_2 cardp_r2 cardp_v2 2.00994193253e-09
Ccardp_2 cardp_v2 0 8.03976773013e-13
Rcardp_3 cardp_v2 cardp_r3 0.0166666666667
Lcardp_3 cardp_r3 cardp_v3 2.00994193253e-09
Ccardp_3 cardp_v3 0 8.03976773013e-13
Rcardp_4 cardp_v3 cardp_r4 0.0166666666667
Lcardp_4 cardp_r4 cardp_v4 2.00994193253e-09
Ccardp_4 cardp_v4 0 8.03976773013e-13
Rcardp_5 cardp_v4 cardp_r5 0.0166666666667
Lcardp_5 cardp_r5 cardp_v5 2.00994193253e-09
Ccardp_5 cardp_v5 0 8.03976773013e-13
Rcardp_6 cardp_v5 cardp_r6 0.0166666666667
Lcardp_6 cardp_r6 cardp_v6 2.00994193253e-09
Ccardp_6 cardp_v6 0 8.03976773013e-13
Rcardp_7 cardp_v6 cardp_r7 0.0166666666667
Lcardp_7 cardp_r7 cardp_v7 2.00994193253e-09
Ccardp_7 cardp_v7 0 8.03976773013e-13
Rcardp_8 cardp_v7 cardp_r8 0.0166666666667
Lcardp_8 cardp_r8 cardp_v8 2.00994193253e-09
Ccardp_8 cardp_v8 0 8.03976773013e-13
Rcardp_9 cardp_v8 cardp_r9 0.0166666666667
Lcardp_9 cardp_r9 cardp_v9 2.00994193253e-09
Ccardp_9 cardp_v9 0 8.03976773013e-13
Rcardp_10 cardp_v9 cardp_r10 0.0166666666667
Lcardp_10 cardp_r10 cardp_v10 2.00994193253e-09
Ccardp_10 cardp_v10 0 8.03976773013e-13
Rcardp_11 cardp_v10 cardp_r11 0.0166666666667
Lcardp_11 cardp_r11 cp 2.00994193253e-09
Ccardp_11 cp 0 4.01988386507e-13
Ccarriern_first dn 0 6.96932226063e-13
Rcarriern_0 dn carriern_r0 0.133333333333
Lcarriern_0 carriern_r0 carriern_v0 3.48466113032e-09
Ccarriern_0 carriern_v0 0 1.39386445213e-12
Rcarriern_1 carriern_v0 carriern_r1 0.133333333333
Lcarriern_1 carriern_r1 carriern_v1 3.48466113032e-09
Ccarriern_1 carriern_v1 0 1.39386445213e-12
Rcarriern_2 carriern_v1 carriern_r2 0.133333333333
Lcarriern_2 carriern_r2 carriern_v2 3.48466113032e-09
Ccarriern_2 carriern_v2 0 1.39386445213e-12
Rcarriern_3 carriern_v2 carriern_r3 0.133333333333
Lcarriern_3 carriern_r3 carriern_v3 3.48466113032e-09
Ccarriern_3 carriern_v3 0 1.39386445213e-12
Rcarriern_4 carriern_v3 carriern_r4 0.133333333333
Lcarriern_4 carriern_r4 carriern_v4 3.48466113032e-09
Ccarriern_4 carriern_v4 0 1.39386445213e-12
Rcarriern_5 carriern_v4 carriern_r5 0.133333333333
Lcarriern_5 carriern_r5 carriern_v5 3.48466113032e-09
Ccarriern_5 carriern_v5 0 1.39386445213e-12
Rcarriern_6 carriern_v5 carriern_r6 0.133333333333
Lcarriern_6 carriern_r6 carriern_v6 3.48466113032e-09
Ccarriern_6 carriern_v6 0 1.39386445213e-12
Rcarriern_7 carriern_v6 carriern_r7 0.133333333333
Lcarriern_7 carriern_r7 carriern_v7 3.48466113032e-09
Ccarriern_7 carriern_v7 0 1.39386445213e-12
Rcarriern_8 carriern_v7 carriern_r8 0.133333333333
Lcarriern_8 carriern_r8 carriern_v8 3.48466113032e-09
Ccarriern_8 carriern_v8 0 1.39386445213e-12
Rcarriern_9 carriern_v8 carriern_r9 0.133333333333
Lcarriern_9 carriern_r9 carriern_v9 3.48466113032e-09
Ccarriern_9 carriern_v9 0 1.39386445213e-12
Rcarriern_10 carriern_v9 carriern_r10 0.133333333333
Lcarriern_10 carriern_r10 carriern_v10 3.48466113032e-09
Ccarriern_10 carriern_v10 0 1.39386445213e-12
Rcarriern_11 carriern_v10 carriern_r11 0.133333333333
Lcarriern_11 carriern_r11 jn 3.48466113032e-09
Ccarriern_11 jn 0 6.96932226063e-13
Ccardn_first jn 0 4.03630065958e-13
Rcardn_0 jn cardn_r0 0.0166666666667
Lcardn_0 cardn_r0 cardn_v0 2.01815032979e-09
Ccardn_0 cardn_v0 0 8.07260131917e-13
Rcardn_1 cardn_v0 cardn_r1 0.0166666666667
Lcardn_1 cardn_r1 cardn_v1 2.01815032979e-09
Ccardn_1 cardn_v1 0 8.07260131917e-13
Rcardn_2 cardn_v1 cardn_r2 0.0166666666667
Lcardn_2 cardn_r2 cardn_v2 2.01815032979e-09
Ccardn_2 cardn_v2 0 8.07260131917e-13
Rcardn_3 cardn_v2 cardn_r3 0.0166666666667
Lcardn_3 cardn_r3 cardn_v3 2.01815032979e-09
Ccardn_3 cardn_v3 0 8.07260131917e-13
Rcardn_4 cardn_v3 cardn_r4 0.0166666666667
Lcardn_4 cardn_r4 cardn_v4 2.01815032979e-09
Ccardn_4 cardn_v4 0 8.07260131917e-13
Rcardn_5 cardn_v4 cardn_r5 0.0166666666667
Lcardn_5 cardn_r5 cardn_v5 2.01815032979e-09
Ccardn_5 cardn_v5 0 8.07260131917e-13
Rcardn_6 cardn_v5 cardn_r6 0.0166666666667
Lcardn_6 cardn_r6 cardn_v6 2.01815032979e-09
Ccardn_6 cardn_v6 0 8.07260131917e-13
Rcardn_7 cardn_v6 cardn_r7 0.0166666666667
Lcardn_7 cardn_r7 cardn_v7 2.01815032979e-09
Ccardn_7 cardn_v7 0 8.07260131917e-13
Rcardn_8 cardn_v7 cardn_r8 0.0166666666667
Lcardn_8 cardn_r8 cardn_v8 2.01815032979e-09
Ccardn_8 cardn_v8 0 8.07260131917e-13
Rcardn_9 cardn_v8 cardn_r9 0.0166666666667
Lcardn_9 cardn_r9 cardn_v9 2.01815032979e-09
Ccardn_9 cardn_v9 0 8.07260131917e-13
Rcardn_10 cardn_v9 cardn_r10 0.0166666666667
Lcardn_10 cardn_r10 cardn_v10 2.01815032979e-09
Ccardn_10 cardn_v10 0 8.07260131917e-13
Rcardn_11 cardn_v10 cardn_r11 0.0166666666667
Lcardn_11 cardn_r11 cn 2.01815032979e-09
Ccardn_11 cn 0 4.03630065958e-13
C61 cp ap 100n
C60 cn an 100n
Vbias bias 0 1.5
Rbiasp ap bias 5k
Rbiasn an bias 5k
Cadcp ap 0 5p
Cadcn an 0 5p
.ic v(ap)=0.6 v(an)=1.5
.options reltol=1e-5 abstol=1e-12
.tran 0.05n 1200n uic
.save v(jp) v(jn) v(ap) v(an) i(Vp) i(Vn)
.end
