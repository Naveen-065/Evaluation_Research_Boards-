ADC LVDS OUT5 connector100: finite-compliance behavioral model
* Driver compliance is ASSUMED; no prediction of silicon damage.
.options reltol=0.002 abstol=1e-9 vntol=1e-6
Vcm cm 0 1.3
Vq q 0 PWL(
+ 0 1
+ 8e-08 1
+ 8.81758333333e-08 1
+ 8.84908333333e-08 -1
+ 9.65091666667e-08 -1
+ 9.68241666667e-08 1
+ 1.21509166667e-07 1
+ 1.21824166667e-07 -1
+ 1.298425e-07 -1
+ 1.301575e-07 1
+ 1.548425e-07 1
+ 1.551575e-07 -1
+ 1.71509166667e-07 -1
+ 1.71824166667e-07 1
+ 1.88175833333e-07 1
+ 1.88490833333e-07 -1
+ 2.048425e-07 -1
+ 2.051575e-07 1
+ 2.13175833333e-07 1
+ 2.13490833333e-07 -1
+ 2.21509166667e-07 -1
+ 2.21824166667e-07 1
+ 2.298425e-07 1
+ 2.301575e-07 -1
+ 2.38175833333e-07 -1
+ 2.38490833333e-07 1
+ 2.46509166667e-07 1
+ 2.46824166667e-07 -1
+ 2.548425e-07 -1
+ 2.551575e-07 1
+ 3.13175833333e-07 1
+ 3.13490833333e-07 -1
+ 3.63175833333e-07 -1
+ 3.63490833333e-07 1
+ 3.71509166667e-07 1
+ 3.71824166667e-07 -1
+ 4.13175833333e-07 -1
+ 4.13490833333e-07 1
+ 4.298425e-07 1
+ 4.301575e-07 -1
+ 4.63175833333e-07 -1
+ 4.63490833333e-07 1
+ 4.71509166667e-07 1
+ 4.71824166667e-07 -1
+ 4.798425e-07 -1
+ 4.801575e-07 1
+ 4.88175833333e-07 1
+ 4.88490833333e-07 -1
+ 5.13175833333e-07 -1
+ 5.13490833333e-07 1
+ 5.46509166667e-07 1
+ 5.46824166667e-07 -1
+ 5.63175833333e-07 -1
+ 5.63490833333e-07 1
+ 5.71509166667e-07 1
+ 5.71824166667e-07 -1
+ 5.96509166667e-07 -1
+ 5.96824166667e-07 1
+ 6.05e-07 1
+ )
Bdrive sn sp I=0.0028*v(q)
Rout sp sn 1meg
Bcompliance sp sn I=(max(v(sp,sn)-0.55,0)-max(-v(sp,sn)-0.55,0))/20
* Assumed ideal fast common-mode regulation, same current in both legs.
Bcmp sp cm I=0.05*(v(sp)+v(sn)-2*v(cm))
Bcmn sn cm I=0.05*(v(sp)+v(sn)-2*v(cm))
Cdp sp 0 2p
Cdn sn 0 2p
* QFN package: TI SBOC249 0.5ohm/2nH/0.3pF per pin.
Rpkp sp spp .5
Lpkp spp dp 2n
Cpkp dp 0 .3p
Rpkn sn snn .5
Lpkn snn dn 2n
Cpkn dn 0 .3p
Tdp dp 0 xp 0 Z0=35.0 TD=5.50337e-10
Rldp xp jp 0.4
Tcp jp 0 yp 0 Z0=55.0 TD=9.635877e-10
Rlcp yp zp 0.4
Lrxp zp rp 1e-09
Crxp rp 0 3e-12
Rleakp rp 0 100meg
Tdn dn 0 xn 0 Z0=35.0 TD=5.685374e-10
Rldn xn jn 0.4
Tcn jn 0 yn 0 Z0=55.0 TD=9.637264e-10
Rlcn yn zn 0.4
Lrxn zn rn 1e-09
Crxn rn 0 3e-12
Rleakn rn 0 100meg
Rconn jp jn 101.0
.tran 25p 6.05e-07 0 25p
.save v(rp) v(rn) v(sp) v(sn) v(jp) v(jn) v(q)
.end
