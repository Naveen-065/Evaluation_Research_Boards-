DAC81416 INPUT1_1p8 TI IBIS clamp table, min corner
* TI SLAM334 / dac81416.ibs, File Rev 1.0, 2018-08-23.
* Powered DC I/V conversion only, not a full FPGA or complete IBIS transient model.
* Assumed FPGA source resistance 25 ohm. Device voltage limits remain mandatory.
Vdrive source 0 0
Rdriver source package 25
Rpackage package pin 0.05
Vio vio 0 1.65
Rpull package vio 10k
Bgnd pin 0 I=pwl(v(pin),
+ -1.8, -1.00558, -1.4436, -0.663464, -1.4382, -0.658331, -1.4274, -0.64807, -1.2006, -0.434969,
+ -1.1952, -0.429967, -1.179, -0.414986, -1.1736, -0.410001, -1.152, -0.39011, -1.1466, -0.38515,
+ -1.044, -0.292062, -1.0062, -0.258464, -0.9522, -0.211381, -0.9468, -0.206745, -0.9414, -0.202123,
+ -0.9036, -0.170232, -0.8928, -0.16129, -0.8874, -0.156851, -0.882, -0.152434, -0.8604, -0.135013,
+ -0.828, -0.10975, -0.8118, -0.0975961, -0.8064, -0.0936275, -0.801, -0.0897037, -0.774, -0.0708461,
+ -0.7254, -0.0410807, -0.6552, -0.0124308, -0.6498, -0.0110737, -0.585, -0.00227722, -0.4446, -5.39072e-05,
+ -0.4392, -4.65303e-05, -0.4338, -4.01403e-05, -0.4284, -3.46082e-05, -0.423, -2.98215e-05, -0.4176, -2.56825e-05,
+ -0.4122, -2.21058e-05, -0.4068, -1.90173e-05, -0.4014, -1.63522e-05, -0.396, -1.40539e-05, -0.3906, -1.20734e-05,
+ -0.3852, -1.03677e-05, -0.3798, -8.89968e-06, -0.3744, -7.63685e-06, -0.369, -6.55113e-06, -0.3636, -5.61812e-06,
+ -0.3528, -4.12856e-06, -0.3474, -3.53791e-06, -0.342, -3.03111e-06, -0.3366, -2.59638e-06, -0.3258, -1.90393e-06,
+ -0.3204, -1.62994e-06, -0.3096, -1.1939e-06, -0.3042, -1.02151e-06, -0.2934, -7.46607e-07, -0.288, -6.38692e-07,
+ -0.2826, -5.46155e-07, -0.2772, -4.66828e-07, -0.261, -2.90521e-07, -0.2394, -1.53675e-07, -0.2178, -8.00987e-08,
+ -0.1422, -5.03385e-09, -0.0666, 0, -0.0126, 0, -0.0072, 0, -0.0018, 0,
+ 0.0036, 0, 0.009, 0, 0.0846, 0, 0.1602, 0, 0.2358, 0,
+ 0.3114, 0, 0.387, 0, 0.4626, 0, 0.5382, 0, 0.6138, 0,
+ 0.6894, 0, 0.765, 0, 0.8406, 0, 0.9162, 0, 0.9594, 0,
+ 0.9972, 0, 1.0728, 0, 1.1484, 0, 1.224, 0, 1.2996, 0,
+ 1.3752, 0, 1.4508, 0, 1.5264, 0, 1.602, 0, 1.6776, 0,
+ 1.7532, 0, 1.8288, 0, 1.9044, 0, 1.98, 0, 2.0556, 0,
+ 2.1312, 0, 2.2068, 0, 2.25, 0, 3.6, 0)
Bpwr pin vio I=pwl(v(vio,pin),
+ -1.8, 0.00112225, -1.4544, 0.00078336, -1.2168, 0.00055386, -1.2114, 0.000548696, -1.152, 0.000492098,
+ -1.1466, 0.000486973, -1.1412, 0.000481851, -1.0602, 0.000405514, -0.9684, 0.000320402, -0.9522, 0.000305585,
+ -0.9468, 0.000300662, -0.9414, 0.000295747, -0.936, 0.000290841, -0.855, 0.000218484, -0.8442, 0.000209047,
+ -0.8388, 0.000204351, -0.8334, 0.000199671, -0.7794, 0.000153879, -0.774, 0.000149418, -0.7686, 0.000144982,
+ -0.7524, 0.000131837, -0.747, 0.000127514, -0.7092, 9.82193e-05, -0.6714, 7.11031e-05, -0.6552, 6.03676e-05,
+ -0.6336, 4.71034e-05, -0.5958, 2.75209e-05, -0.5904, 2.51675e-05, -0.531, 7.46507e-06, -0.4446, 7.44347e-07,
+ -0.4392, 6.3869e-07, -0.4338, 5.47763e-07, -0.4284, 4.69575e-07, -0.423, 4.02381e-07, -0.4176, 3.44671e-07,
+ -0.4122, 2.95126e-07, -0.4068, 2.52607e-07, -0.4014, 2.1613e-07, -0.396, 1.84846e-07, -0.3906, 1.58021e-07,
+ -0.3852, 1.35025e-07, -0.3798, 1.15315e-07, -0.3744, 9.84488e-08, -0.369, 8.39458e-08, -0.3636, 7.15422e-08,
+ -0.3582, 6.09152e-08, -0.3528, 5.18097e-08, -0.3474, 4.40097e-08, -0.342, 3.73277e-08, -0.3366, 3.16103e-08,
+ -0.3258, 2.24986e-08, -0.3204, 1.88999e-08, -0.3096, 1.31769e-08, -0.2934, 7.29101e-09, -0.288, 5.87748e-09,
+ -0.2826, 4.66107e-09, -0.261, 1.31205e-09, -0.2502, 2.68073e-10, -0.2394, 0, -0.2178, 0,
+ -0.1422, 0, -0.0666, 0, -0.0126, 0, -0.0072, 0, -0.0018, 0,
+ 0.0036, 0, 0.009, 0, 0.0846, 0, 0.1602, 0, 0.2358, 0,
+ 0.3114, 0, 0.387, 0, 0.4626, 0, 0.5382, 0, 0.6138, 0,
+ 0.6894, 0, 0.765, 0, 0.8406, 0, 0.9162, 0, 0.9594, 0,
+ 0.9972, 0, 1.0728, 0, 1.1484, 0, 1.224, 0, 1.2996, 0,
+ 1.3752, 0, 1.4508, 0, 1.5264, 0, 1.602, 0, 1.6776, 0,
+ 1.7532, 0, 1.8288, 0, 1.9044, 0, 1.98, 0, 2.0556, 0,
+ 2.1312, 0, 2.2068, 0, 2.25, 0, 3.6, 0)
.dc Vdrive 0 3.3 0.01
.save v(source) v(package) v(pin) i(Vdrive)
.end
