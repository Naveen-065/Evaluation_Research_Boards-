TI powered input clamp, INPUT1_1p8, additional resistance 33 ohm
* Nominal 1.8V model only. Optional 10k pullup represents CS or RESET.
* Bare case represents SCLK/SDI, which have no external pullup on this PCB.
* INPUT2 is RESET. Extra resistance is not a proposed level translator.
Vdrive source 0 0
Rdriver source package 58
Rpackage package pin 0.05
Vio vio 0 1.8
Rpull package vio 10k
Bgnd pin 0 I=pwl(v(pin),
+ -1.8, -0.883864, -1.4436, -0.540147, -1.4382, -0.534994, -1.4274, -0.524695, -1.2006, -0.311355,
+ -1.1952, -0.306371, -1.179, -0.29146, -1.1736, -0.286503, -1.152, -0.266748, -1.1466, -0.261829,
+ -1.044, -0.170346, -1.0062, -0.138003, -0.9522, -0.0939827, -0.9468, -0.0897751, -0.9414, -0.0856119,
+ -0.9036, -0.0579871, -0.8928, -0.0507051, -0.8874, -0.0471912, -0.882, -0.0437702, -0.8604, -0.0311517,
+ -0.828, -0.0162207, -0.8118, -0.0108939, -0.8064, -0.00944522, -0.801, -0.00815331, -0.774, -0.00373627,
+ -0.7254, -0.00093697, -0.6552, -0.000184016, -0.6498, -0.000164053, -0.585, -4.118e-05, -0.4446, -1.2339e-06,
+ -0.4392, -1.05434e-06, -0.4338, -8.99192e-07, -0.4284, -7.65405e-07, -0.423, -6.58404e-07, -0.4176, -5.51403e-07,
+ -0.4122, -4.66664e-07, -0.4068, -3.94183e-07, -0.4014, -3.3231e-07, -0.396, -2.79594e-07, -0.3906, -2.34767e-07,
+ -0.3852, -1.96718e-07, -0.3798, -1.64481e-07, -0.3744, -1.37216e-07, -0.369, -1.14195e-07, -0.3636, -9.47907e-08,
+ -0.3528, -6.47379e-08, -0.3474, -5.32243e-08, -0.342, -4.35784e-08, -0.3366, -3.5508e-08, -0.3258, -2.31383e-08,
+ -0.3204, -1.84492e-08, -0.3096, -1.13015e-08, -0.3042, -8.60721e-09, -0.2934, -4.50667e-09, -0.288, -2.98287e-09,
+ -0.2826, -1.72112e-09, -0.2772, -6.77882e-10, -0.261, 0, -0.2394, 0, -0.2178, 0,
+ -0.1422, 0, -0.0666, 0, -0.0126, 0, -0.0072, 0, -0.0018, 0,
+ 0.0036, 0, 0.009, 0, 0.0846, 0, 0.1602, 0, 0.2358, 0,
+ 0.3114, 0, 0.387, 0, 0.4626, 0, 0.5382, 0, 0.6138, 0,
+ 0.6894, 0, 0.765, 0, 0.8406, 0, 0.9162, 0, 0.9594, 0,
+ 0.9972, 0, 1.0728, 0, 1.1484, 0, 1.224, 0, 1.2996, 0,
+ 1.3752, 0, 1.4508, 0, 1.5264, 0, 1.602, 0, 1.6776, 0,
+ 1.7532, 0, 1.8288, 0, 1.9044, 0, 1.98, 0, 2.0556, 0,
+ 2.1312, 0, 2.2068, 0, 2.25, 0, 3.6, 0)
Bpwr pin vio I=pwl(v(vio,pin),
+ -1.8, 0.00119193, -1.4544, 0.000774063, -1.2168, 0.000492086, -1.2114, 0.000485768, -1.152, 0.000416656,
+ -1.1466, 0.000410413, -1.1412, 0.000404178, -1.0602, 0.000311695, -0.9684, 0.000210365, -0.9522, 0.000193069,
+ -0.9468, 0.000187356, -0.9414, 0.000181671, -0.936, 0.000176015, -0.855, 9.6022e-05, -0.8442, 8.63197e-05,
+ -0.8388, 8.15878e-05, -0.8334, 7.69423e-05, -0.7794, 3.66426e-05, -0.774, 3.33856e-05, -0.7686, 3.02977e-05,
+ -0.7524, 2.20991e-05, -0.747, 1.9732e-05, -0.7092, 8.08149e-06, -0.6714, 2.96933e-06, -0.6552, 1.91099e-06,
+ -0.6336, 1.05898e-06, -0.5958, 3.74224e-07, -0.5904, 3.22067e-07, -0.531, 5.83973e-08, -0.4446, 2.08745e-09,
+ -0.4392, 1.3709e-09, -0.4338, 7.61483e-10, -0.4284, 2.428e-10, -0.423, 1.214e-10, -0.4176, 0,
+ -0.4122, 0, -0.4068, 0, -0.4014, 0, -0.396, 0, -0.3906, 0,
+ -0.3852, 0, -0.3798, 0, -0.3744, 0, -0.369, 0, -0.3636, 0,
+ -0.3582, 0, -0.3528, 0, -0.3474, 0, -0.342, 0, -0.3366, 0,
+ -0.3258, 0, -0.3204, 0, -0.3096, 0, -0.2934, 0, -0.288, 0,
+ -0.2826, 0, -0.261, 0, -0.2502, 0, -0.2394, 0, -0.2178, 0,
+ -0.1422, 0, -0.0666, 0, -0.0126, 0, -0.0072, 0, -0.0018, 0,
+ 0.0036, 0, 0.009, 0, 0.0846, 0, 0.1602, 0, 0.2358, 0,
+ 0.3114, 0, 0.387, 0, 0.4626, 0, 0.5382, 0, 0.6138, 0,
+ 0.6894, 0, 0.765, 0, 0.8406, 0, 0.9162, 0, 0.9594, 0,
+ 0.9972, 0, 1.0728, 0, 1.1484, 0, 1.224, 0, 1.2996, 0,
+ 1.3752, 0, 1.4508, 0, 1.5264, 0, 1.602, 0, 1.6776, 0,
+ 1.7532, 0, 1.8288, 0, 1.9044, 0, 1.98, 0, 2.0556, 0,
+ 2.1312, 0, 2.2068, 0, 2.25, 0, 3.6, 0)
.dc Vdrive 0 3.3 0.01
.save v(source) v(package) v(pin) i(Vdrive)
.end
